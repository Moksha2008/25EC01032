MOSFET Level 1 Id-Vds sweep
.model NMOS1 NMOS (LEVEL=1 VTO=-0.4758 KP=1.3812e-4 GAMMA=0.1668 PHI=0.7144
+ LAMBDA=0.1 TOX=10e-9 NSUB=1e16)

M1 D G 0 0 NMOS1 W=4u L=0.18u
VDS D 0 0
VGS G 0 0

.control
dc VDS 0 4 0.05 VGS 1 3 1
wrdata level1_output.csv v(d) i(vds) v(g)
.endc
.end
